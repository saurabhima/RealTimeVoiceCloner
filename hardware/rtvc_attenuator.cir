* RealTimeVoiceCloner attenuator: USB adapter headphone-out -> phone mic input
* Load in LTspice / ngspice / KiCad simulator. Expect about -41 dB flat over 300 Hz - 8 kHz at node MIC.
* Adapter output (1 V peak, same signal on L and R, 10 ohm output impedance each)
V1   sig  0   AC 1
Rs1  sig  l   10
Rs2  sig  r   10
* Circuit (matches the schematic and netlist)
R1   l    mixed 10k
R2   r    mixed 10k
R3   mixed 0    47
C1   mic  mixed 4.7u
R4   mic  0     2.2k
* Phone microphone bias: about 2.2 V through 2.2k
Vb   vb   0     DC 2.2
Rb   vb   mic   2.2k
.ac dec 20 20 20k
.meas ac gain_1k find vdb(mic) at=1k
.end
